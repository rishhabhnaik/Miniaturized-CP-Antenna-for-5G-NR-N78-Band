# Ansys Electronics Desktop project, version 2020.2
materials:
  vacuum: permittivity=1
  F4BM: permittivity=2.2 dielectric_loss_tangent=0.001
  copper: permeability=0.999991 conductivity=58000000

design HFSSDesign1 (HFSS, DrivenModal, model units mm)
variables:
  g = 60mm
  w = 25mm
  w2 = 6mm
  g1 = 1mm
  g2 = 0.93mm
  s1 = 1.5mm
  s2 = 2.55mm
  s3 = 1.5mm
  s4 = 0.5mm
  sw = 1mm
  sl = 20.5mm
  l = 5mm
  h = 3mm
  F4BM_thickness = 0.508mm
  sheetwidth = 0.3mm  # width of metallic sheet connecting the baseboard and radiating board
  r1 = 16mm  # radius of the ring
  CL = 1.8pF  # lumped LH capactitor
  LL = 1nH  # lumped LH inductor
  SMD_w = 0.3mm  # SMD width
  SMD_l = 0.6mm  # SMD length
  tjunction_l = 20mm  # total length of tjuction branch; optimise 7.73mm..23.19mm; tune 10mm..30mm
  tjunction_l_b1 = 4mm  # first tjunction branchline tab length
  tjunction_1_b2 = 2mm  # second tjunction branchline tab length
  port_length = 4mm
geometry:
  Board1 [F4BM] = box(corner=(-g/2, -g/2, 0mm), size=(g, g, F4BM_thickness))
  coordinate_system Antenna CS = object of Board1: Origin=centre of Board1.face(-z) xAxis{xDirection=1 yDirection=0 zDirection=0} yAxis{xDirection=0 yDirection=1 zDirection=0}
  FeedLine1 = rectangle(corner=(g/2, -s1/2, 0), x_size=-(g/2-r1), y_size=s1) in Antenna CS
  FeedLine2 = rectangle(corner=(-s1/2, -g/2, 0mm), x_size=s1, y_size=(g/2-r1)) in Antenna CS
  Circle1 = circle(normal=Z, centre=(0mm, 0mm, 0mm), radius=r1-s3/2) in Antenna CS
  Circle2 = circle(normal=Z, centre=(0mm, 0mm, 0mm), radius=r1+s3/2) in Antenna CS
  Circle2.subtract(Circle1)
  Circle2_Split1 = Circle2.split(plane=ZX, keep=Both) in Antenna CS
  Circle2_Split1.split(plane=YZ, keep=Both) in Antenna CS
  Circle2_Split2 = Circle2.split(plane=YZ, keep=Both) in Antenna CS
  Circle2.delete()
  Circle3 = circle(normal=Z, centre=(0mm, 0mm, 0mm), radius=r1+s2/2) in Antenna CS
  Circle4 = circle(normal=Z, centre=(0mm, 0mm, 0mm), radius=r1-s2/2) in Antenna CS
  Circle3.subtract(Circle4)
  Circle3_Split1 = Circle3.split(plane=YZ, keep=Both) in Antenna CS
  Circle3_Split1_Split1 = Circle3_Split1.split(plane=ZX, keep=Both) in Antenna CS
  Circle3_Split1.delete()
  Circle3.split(plane=ZX, keep=Both) in Antenna CS
  RingChamfer1 [non-model] = rectangle(corner=(0, 0mm, 0.5mm), z_size=-1mm, x_size=(r1-s3/2)*sqrt(2)) in Antenna CS
  RingChamfer1.rotate(axis=Z, angle=-45deg) in Antenna CS
  RingChamfer1.move(0mm, r1-s3/2, 0mm) in Antenna CS
  Circle3_Split1_Split1.split(plane=Rectangle1_1.face, keep=PositiveOnly) in Antenna CS
  Rectangle1_1 = RingChamfer1.copy()
  Rectangle1_1.delete()
  RingChamfer1.move(-(r1-s3/2), -(r1-s3/2), 0) in Antenna CS
  Circle3.split(plane=Rectangle1_2.face, keep=NegativeOnly) in Antenna CS
  Rectangle1_2 = RingChamfer1.copy()
  Rectangle1_2.delete()
  RingChamfer2 [non-model] = rectangle(corner=(0mm, 0mm, -0.5mm), z_size=1mm, x_size=(r1+s2)*sqrt(2)) in Antenna CS
  RingChamfer2.rotate(axis=Z, angle=45deg) in Antenna CS
  RingChamfer2.move(-(r1+s3), -s3/2, 0mm) in Antenna CS
  Circle3.split(plane=Rectangle2_1.face, keep=PositiveOnly) in Antenna CS
  Rectangle2_1 = RingChamfer2.copy()
  Rectangle2_1.delete()
  Circle3_Split1_Split1.split(plane=Rectangle2_2.face, keep=PositiveOnly) in Antenna CS
  Rectangle2_2 = RingChamfer2.copy()
  Rectangle2_2.delete()
  RingGap1 = rectangle(corner=(r1-s2*1.5/2, -(SMD_l+SMD_w), 0mm), x_size=s2*1.5, y_size=SMD_l) in Antenna CS
  RingLumpedTee = rectangle(corner=(r1, -SMD_w, 0mm), x_size=s2/2, y_size=SMD_w*2) in Antenna CS
  RingLumpedC1 = rectangle(corner=(r1-SMD_w/2, SMD_w, 0mm), x_size=SMD_w, y_size=SMD_l) in Antenna CS
  RingLumpedL1 = rectangle(corner=(r1+s2/2, -SMD_w/2, 0mm), x_size=SMD_l, y_size=SMD_w) in Antenna CS
  RingLumpedC2 = RingLumpedC1.duplicate_mirror(point=(r1, 0mm, 0mm), normal=(0mm, -1mm, 0mm)) in Antenna CS
  Ring = rectangle(corner=(r1+s2/2+SMD_l, -SMD_w, 0mm), x_size=SMD_w*3, y_size=SMD_w*2) in Antenna CS
  Via [copper] = cylinder(axis=Z, base_centre=(r1+s2/2+SMD_l+SMD_w*2, 0, 0mm), radius=0.25mm, height=F4BM_thickness) in Antenna CS
  [RingLumpedTee, RingLumpedC1, RingLumpedL1, RingLumpedC2, Ring, Via].rotate(axis=Z, angle=45deg) in Antenna CS
  RingGap1_1 = RingGap1.duplicate_mirror(point=(r1, 0mm, 0mm), normal=(0mm, 1mm, 0mm)) in Antenna CS
  RingGap1.unite(RingGap1_1)
  RingGap1.rotate(axis=Z, angle=45deg) in Antenna CS
  RingGap1.duplicate_around_axis(axis=Z, angle=90deg, total=4, attached) in Antenna CS
  RingGap1_2 = RingGap1.copy()
  Circle2_Split1.subtract(RingGap1_2)
  RingGap1_3 = RingGap1.copy()
  Circle2_Split2.subtract(RingGap1_3)
  RingGap1_4 = RingGap1.copy()
  Circle3.subtract(RingGap1_4)
  Circle3_Split1_Split1.subtract(RingGap1)
  Ring.duplicate_around_axis(axis=Z, angle=90deg, total=4, attached) in Antenna CS
  RingLumpedTee.duplicate_around_axis(axis=Z, angle=90deg, total=4, attached) in Antenna CS
  Ring.unite(RingLumpedTee, Circle2_Split1, Circle2_Split2, Circle3, Circle3_Split1_Split1)
  RingLumpedC1_1, RingLumpedC1_2, RingLumpedC1_3 = RingLumpedC1.duplicate_around_axis(axis=Z, angle=90deg, total=4) in Antenna CS
  RingLumpedC2_1, RingLumpedC2_2, RingLumpedC2_3 = RingLumpedC2.duplicate_around_axis(axis=Z, angle=90deg, total=4) in Antenna CS
  RingLumpedL1_1, RingLumpedL1_2, RingLumpedL1_3 = RingLumpedL1.duplicate_around_axis(axis=Z, angle=90deg, total=4) in Antenna CS
  Via.duplicate_around_axis(axis=Z, angle=90deg, total=4, attached) in Antenna CS
  GndPlane = rectangle(corner=(-g/2, -g/2, F4BM_thickness), x_size=g, y_size=g) in Antenna CS
  Slot = rectangle(corner=(-sl/2, -sw/2, F4BM_thickness), x_size=sl, y_size=sw) in Antenna CS
  Slot_1 = Slot.duplicate_mirror(point=(0mm, 0mm, 0mm), normal=(1mm, 1mm, 0mm)) in Antenna CS
  GndPlane.subtract(Slot, Slot_1)
  Tjunc_Port = rectangle(corner=(-r1, -s1/2, 0mm), x_size=port_length, y_size=s1) in Antenna CS
  coordinate_system Branchline CS = object of Tjunc_Port: Origin=middle of Tjunc_Port.edge(2 of 4) xAxis{xDirection=1 yDirection=0 zDirection=0} yAxis{xDirection=0 yDirection=1 zDirection=0} in Antenna CS
  Tjunc_Branch_Tab1 = rectangle(corner=(0mm, 0mm, 0mm), x_size=s4, y_size=tjunction_l_b1) in Branchline CS
  Tjunc_Branch_Beam = rectangle(corner=(0mm, tjunction_l_b1, 0mm), x_size=tjunction_l-tjunction_l_b1-tjunction_1_b2, y_size=s4) in Branchline CS
  Tjunc_Chamfer_Plane [non-model] = rectangle(corner=(0mm, 0mm, -0.5mm), y_size=s4*sqrt(2), z_size=1mm) in Branchline CS
  Tjunc_Chamfer_Plane.rotate(axis=Z, angle=-45deg) in Branchline CS
  Tjunc_Chamfer_Plane.move(0, tjunction_l_b1, 0) in Branchline CS
  Tjunc_Branch_Beam.split(plane=Rectangle4_1.face, keep=NegativeOnly) in Branchline CS
  Rectangle4_1 = Tjunc_Chamfer_Plane.copy()
  Rectangle4_1.delete()
  Tjunc_Branch1 = rectangle(corner=(tjunction_l-tjunction_l_b1-tjunction_1_b2, tjunction_l_b1, 0mm), x_size=s4, y_size=tjunction_1_b2) in Branchline CS
  Tjunc_Chamfer_Plane.move(tjunction_l-tjunction_l_b1-tjunction_1_b2, 0mm, 0mm) in Branchline CS
  Tjunc_Branch1.split(plane=Rectangle4_2.face, keep=PositiveOnly) in Branchline CS
  Rectangle4_2 = Tjunc_Chamfer_Plane.copy()
  Rectangle4_2.delete()
  Tjunc_Branch1.unite(Tjunc_Branch_Beam, Tjunc_Branch_Tab1)
  Tjunc_Branch2 = Tjunc_Branch1.duplicate_mirror(point=(0mm, 0mm, 0mm), normal=(0mm, -1mm, 0mm)) in Branchline CS
  Tjunc_Branch1.duplicate_around_axis(axis=Z, angle=-90deg, total=2, attached) in Antenna CS
  Tjunc_Branch2.duplicate_around_axis(axis=Z, angle=-90deg, total=2, attached) in Antenna CS
  Tjunc_Port.duplicate_around_axis(axis=Z, angle=-90deg, total=2, attached) in Antenna CS
  coordinate_system Branchline Via CS = origin=(r1-tjunction_l_b1-port_length-s4, tjunction_l_b1+s4/2, 0mm) x=(1mm, 0mm, 0mm) y=(0mm, 1mm, 0mm) in Branchline CS
  TraceMask = rectangle(corner=(0mm, -2*s4, 0mm), x_size=s4, y_size=s4*4) in Branchline Via CS
  Circle5 = circle(normal=Z, centre=(s4/2, s4*2, 0mm), radius=s4) in Branchline Via CS
  Tjunc_Via1 [copper] = cylinder(axis=Z, base_centre=(s4/2, s4*2, 0mm), radius=s4/2, height=F4BM_thickness) in Branchline Via CS
  Circle5_1 = Circle5.duplicate_mirror(point=(0mm, 0mm, 0mm), normal=(0mm, -1mm, 0mm)) in Branchline Via CS
  Tjunc_Via2 [copper] = Tjunc_Via1.duplicate_mirror(point=(0mm, 0mm, 0mm), normal=(0mm, -1mm, 0mm)) in Branchline Via CS
  Tjunc_Via_Top = TraceMask.duplicate_along_line(step=(0mm, 0mm, F4BM_thickness), total=2) in Branchline Via CS
  Circle5_1_1 = Circle5_1.duplicate_along_line(step=(0mm, 0mm, F4BM_thickness), total=2) in Branchline Via CS
  Circle5_2 = Circle5.duplicate_along_line(step=(0mm, 0mm, F4BM_thickness), total=2) in Branchline Via CS
  Tjunc_Branch2.subtract(TraceMask)
  TraceMask2 = rectangle(corner=(-1.5*s4+s4/2, -7/2*s4, F4BM_thickness), x_size=3*s4, y_size=7*s4) in Branchline Via CS
  GndPlane.subtract(TraceMask2)
  Tjunc_Via_Top.unite(Circle5_2, Circle5_1_1)
  Tjunc_Branch2.unite(Circle5, Circle5_1)
  Board2 [F4BM] = box(corner=(-w/2, -w/2, F4BM_thickness+h), size=(w, w, F4BM_thickness)) in Antenna CS
  AntennaPlane = rectangle(corner=(-w/2, -w/2, 2*F4BM_thickness+h), x_size=w, y_size=w) in Antenna CS
  AntennaGap2 = rectangle(corner=(-g2/2, -w/sqrt(2), 2*F4BM_thickness+h), x_size=g2, y_size=w*sqrt(2)) in Antenna CS
  AntennaGap1 = rectangle(corner=(-w/sqrt(2), -g1/2, 2*F4BM_thickness+h), x_size=w*sqrt(2), y_size=g1) in Antenna CS
  MetallicSheet1 [copper] = box(corner=(-l/2, -w/2, F4BM_thickness), size=(l, w2/2, h+F4BM_thickness)) in Antenna CS
  MetallicSheetMask = box(corner=(-l/2, -w/2+sheetwidth, F4BM_thickness+sheetwidth), size=(l, w2/2-sheetwidth, h-sheetwidth+F4BM_thickness)) in Antenna CS
  MetallicSheet1.subtract(MetallicSheetMask)
  AntennaGapSquare = rectangle(corner=(-(w/2-w2), -(w/2-w2), 2*F4BM_thickness+h), x_size=w-2*w2, y_size=w-2*w2) in Antenna CS
  AntennaPlane.subtract(AntennaGapSquare)
  MetallicSheet1.duplicate_around_axis(axis=Z, angle=90deg, total=4, attached) in Antenna CS
  MetallicSheet1_1 = MetallicSheet1.copy()
  Board2.subtract(MetallicSheet1_1)
  [MetallicSheet1, Board2, AntennaPlane].rotate(axis=Z, angle=45deg) in Antenna CS
  AntennaPlane.subtract(AntennaGap1, AntennaGap2)
  Port1 = rectangle(corner=(g/2, -s1/2, 0mm), y_size=s1, z_size=F4BM_thickness) in Antenna CS
  Port2 = Port1.duplicate_around_axis(axis=Z, angle=-90deg, total=2) in Antenna CS
  RadBox [vacuum] = box(corner=(-g, -g, -g), size=(2*g, 2*g, 2*g)) in Antenna CS
  group Feed_Lines = FeedLine1, FeedLine2
  group Ring_Group = RingChamfer1, RingChamfer2, Ring, Via
  group Feed_Board = Board1, GndPlane
  group LumpedElements = RingLumpedC1, RingLumpedL1, RingLumpedC2, RingLumpedC1_1, RingLumpedC1_2, RingLumpedC1_3, RingLumpedC2_1, RingLumpedC2_2, RingLumpedC2_3, RingLumpedL1_1, RingLumpedL1_2, RingLumpedL1_3
  group Tjunc_Group = Tjunc_Port, Tjunc_Chamfer_Plane, Tjunc_Branch1, Tjunc_Branch2
  group Tjunc_Via_Group = Tjunc_Via1, Tjunc_Via2, Tjunc_Via_Top
  group Radiating_Board_and_Sheets = Board2, AntennaPlane, MetallicSheet1
boundaries and excitations:
  C1: Lumped RLC Objects=RingLumpedC1_3 CurrentLine{middle of RingLumpedC1_3.edge(3 of 4) -> middle of RingLumpedC1_3.edge(1 of 4)} RLC_Type=Serial Capacitance=CL
  C2: Lumped RLC Objects=RingLumpedC2_3 CurrentLine{middle of RingLumpedC2_3.edge(1 of 4) -> middle of RingLumpedC2_3.edge(3 of 4)} RLC_Type=Serial Capacitance=CL
  C3: Lumped RLC Objects=RingLumpedC1_2 CurrentLine{RingLumpedC1_2.edge(3 of 4) at 0.585 along -> middle of RingLumpedC1_2.edge(1 of 4)} RLC_Type=Serial Capacitance=CL
  C4: Lumped RLC Objects=RingLumpedC2_2 CurrentLine{middle of RingLumpedC2_2.edge(1 of 4) -> middle of RingLumpedC2_2.edge(3 of 4)} RLC_Type=Serial Capacitance=CL
  C5: Lumped RLC Objects=RingLumpedC1_1 CurrentLine{middle of RingLumpedC1_1.edge(3 of 4) -> middle of RingLumpedC1_1.edge(1 of 4)} RLC_Type=Serial Capacitance=CL
  C6: Lumped RLC Objects=RingLumpedC2_1 CurrentLine{middle of RingLumpedC2_1.edge(1 of 4) -> middle of RingLumpedC2_1.edge(3 of 4)} RLC_Type=Serial Capacitance=CL
  C7: Lumped RLC Objects=RingLumpedC1 CurrentLine{middle of RingLumpedC1.edge(3 of 4) -> RingLumpedC1.edge(1 of 4) at 0.495 along} RLC_Type=Serial Capacitance=0pF
  C8: Lumped RLC Objects=RingLumpedC2 CurrentLine{RingLumpedC2.edge(1 of 4) at 0.495 along -> RingLumpedC2.edge(3 of 4) at 0.585 along} RLC_Type=Serial Capacitance=CL
  L1: Lumped RLC Objects=RingLumpedL1_3 CurrentLine{middle of RingLumpedL1_3.edge(4 of 4) -> middle of RingLumpedL1_3.edge(2 of 4)} RLC_Type=Serial Inductance=LL
  L2: Lumped RLC Objects=RingLumpedL1_2 CurrentLine{middle of RingLumpedL1_2.edge(4 of 4) -> middle of RingLumpedL1_2.edge(2 of 4)} RLC_Type=Serial Inductance=LL
  L3: Lumped RLC Objects=RingLumpedL1_1 CurrentLine{middle of RingLumpedL1_1.edge(4 of 4) -> middle of RingLumpedL1_1.edge(2 of 4)} RLC_Type=Serial Inductance=LL
  L4: Lumped RLC Objects=RingLumpedL1 CurrentLine{middle of RingLumpedL1.edge(4 of 4) -> middle of RingLumpedL1.edge(2 of 4)} RLC_Type=Parallel Inductance=LL
  PerfE1: Perfect E Objects=[Tjunc_Via_Top, Tjunc_Branch1, Tjunc_Branch2, Tjunc_Port, FeedLine1, FeedLine2, Ring]
  PerfE2: Perfect E Objects=GndPlane
  PerfE3: Perfect E Objects=AntennaPlane
  Rad1: Radiation Objects=RadBox
  1: Lumped Port Objects=Port1 Modes{Mode1{IntLine{middle of Port1.edge(3 of 4) -> middle of Port1.edge(1 of 4)} CharImp=Zpi RenormImp=50ohm}} Impedance=50ohm
  2: Lumped Port Objects=Port2 Modes{Mode1{IntLine{middle of Port2.edge(3 of 4) -> middle of Port2.edge(1 of 4)} CharImp=Zpi RenormImp=50ohm}} Impedance=50ohm
setups:
  Setup1: HfssDriven Frequency=3.6GHz MaxDeltaS=0.02 MaximumPasses=6 MinimumPasses=1 MinimumConvergedPasses=1 PercentRefinement=30 BasisOrder=1 PortAccuracy=2
    sweep Sweep: 3.2GHz to 4GHz, 401 points; Type=Interpolating SaveFields InterpTolerance=0.5 InterpMaxSolns=250 InterpUsePortImped=false PassivityErrorTolerance=0.0001
source amplitudes:
  1:1: 1W 0deg
  2:1: 0W 0deg
optimetrics:
  ParametricSetup1: Parametric disabled
    sweep tjunction_l: LIN 7.73mm 23.19mm 0.5mm
radiation setups:
  Infinite Sphere1: Infinite Sphere Theta=0deg..180deg step 2deg Phi=-180deg..180deg step 2deg
field plots:
  Mag_E 0deg: E Field over AntennaPlane.face(all 4) on Setup1 : LastAdaptive at Freq=3.6GHz Phase=0deg
  Mag_E 90deg: E Field over AntennaPlane.face(all 4) on Setup1 : LastAdaptive at Freq=3.6GHz Phase=90deg
  Mag_Jsurf1: Jsurf over MetallicSheet1.face(all 32) AntennaPlane.face(all 4) GndPlane.face(at (0, 0, 0.508)) on Setup1 : LastAdaptive at Freq=3.6GHz Phase=0deg
reports:
  Gain Plot 1: dB(GainTotal) vs Phi, Theta on Setup1 : LastAdaptive, Infinite Sphere1 [Freq=3.6GHz]
  S Parameters: dB(ActiveS(1:1)), dB(ActiveS(2:1)) vs Freq on Setup1 : Sweep [tjunction_l_b1=all]
  Axial Ratio Plot 1: dB(AxialRatioValue) vs Theta on Setup1 : Sweep, Infinite Sphere1 [Phi=all Freq=3.6GHz tjunction_l_b1=all]
  PeakGain: dB(PeakGain) vs Freq on Setup1 : Sweep
