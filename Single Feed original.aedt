# Ansys Electronics Desktop project, version 2020.2
materials:
  vacuum: permittivity=1
  copper: permeability=0.999991 conductivity=58000000
  F4BM: permittivity=2.2 dielectric_loss_tangent=0.001 delta_H_freq=9.4GHz
  perfect conductor: conductivity=1e+30
  FR4_epoxy: permittivity=4.4 dielectric_loss_tangent=0.02
  GIL GML1032 (tm): permittivity=3.2 dielectric_loss_tangent=0.003

design HFSSDesign1 (HFSS, DrivenModal, model units mm)
variables:
  g = 50mm
  F4BM_thickness = 0.508mm
  w = 25mm
  w2 = 6mm
  g1 = 0.91mm
  g2 = 0.49mm
  sw = 1mm
  sl = 18.35mm
  fl = 29.3mm
  fw = 1.5mm
  l = 5mm
  h = 3mm
  sheetwidth = 0.3mm
geometry:
  GndPlane = rectangle(corner=(-g/2, -g/2, F4BM_thickness), x_size=g, y_size=g) in BaseRefCoords
  Board1 [F4BM] = box(corner=(-g/2, -g/2, 0mm), size=(g, g, F4BM_thickness))
  FeedLine = rectangle(corner=(g/2-fl, -fw/2, 0), x_size=fl, y_size=fw) in BaseRefCoords
  GndEtch = rectangle(corner=(-sw/2, -sl/2, F4BM_thickness), x_size=sw, y_size=sl) in BaseRefCoords
  GndEtch.rotate(axis=Z, angle=45deg) in BaseRefCoords
  Board2 [F4BM] = box(corner=(-w/2, -w/2, F4BM_thickness+h), size=(w, w, F4BM_thickness)) in BaseRefCoords
  AntennaPlane = rectangle(corner=(-w/2, -w/2, 2*F4BM_thickness+h), x_size=w, y_size=w) in BaseRefCoords
  AntennaGap1 = rectangle(corner=(-g1/2, -w/sqrt(2), 2*F4BM_thickness+h), x_size=g1, y_size=w*sqrt(2)) in BaseRefCoords
  AntennaGap1.rotate(axis=Z, angle=45deg) in BaseRefCoords
  AntennaGap1.move(g/2, g/2, 0mm) in BaseRefCoords  # suppressed
  AntennaGap2 = rectangle(corner=(-g2/2, -w/sqrt(2), 2*F4BM_thickness+h), x_size=g2, y_size=w*sqrt(2)) in BaseRefCoords
  AntennaGap2.rotate(axis=Z, angle=-45deg) in BaseRefCoords
  AntennaGap2.move(g/2, g/2, 0mm) in BaseRefCoords  # suppressed
  AntennaSquareGap = rectangle(corner=((-w+2*w2)/2, (-w+2*w2)/2, 2*F4BM_thickness+h), x_size=w-2*w2, y_size=w-2*w2) in BaseRefCoords
  AntennaPlane.subtract(AntennaGap1, AntennaGap2, AntennaSquareGap)
  MetallicSheet [copper] = box(corner=(0, 0, F4BM_thickness), size=(l, w2/2, h+F4BM_thickness)) in BaseRefCoords
  Box4 = box(corner=(0, sheetwidth, F4BM_thickness+sheetwidth), size=(l, w2/2-sheetwidth, h+F4BM_thickness-sheetwidth)) in BaseRefCoords
  MetallicSheet.subtract(Box4)
  MetallicSheet.move(-l/2, 0-w/2, 0) in BaseRefCoords
  MetallicSheet_1, MetallicSheet_2, MetallicSheet_3 = MetallicSheet.duplicate_around_axis(axis=Z, angle=90deg, total=4) in BaseRefCoords
  MetallicSheet.unite(MetallicSheet_1, MetallicSheet_2, MetallicSheet_3)
  Port1 = rectangle(corner=(g/2, -fw/2, 0), y_size=fw, z_size=F4BM_thickness) in BaseRefCoords
  RadBox [vacuum, oriented by BaseRefCoords] = box(corner=(-g, -g, -g), size=(2*g, 2*g, 2*g)) in BaseRefCoords
  MetallicSheet_4 = MetallicSheet.copy()
  Board2.subtract(MetallicSheet_4)
  GndEtch_1 = GndEtch.duplicate_around_axis(axis=Z, angle=90deg, total=2) in BaseRefCoords
  GndPlane.subtract(GndEtch, GndEtch_1)
  coordinate_system BaseRefCoords = object of Board1: Origin=centre of Board1.face(-z) xAxis{xDirection=1 yDirection=0 zDirection=0} yAxis{xDirection=0 yDirection=1 zDirection=0}
  group Base_Board = GndPlane, Board1, FeedLine, Port1
  group Radiating_Board = Board2, AntennaPlane, MetallicSheet
  group RadBox_Group = RadBox
boundaries and excitations:
  Ground: Perfect E Objects=GndPlane
  Feed: Perfect E Objects=FeedLine
  Antenna: Perfect E Objects=AntennaPlane
  RadBox: Radiation Objects=RadBox
  1: Lumped Port Objects=Port1 Modes{Mode1{IntLine{middle of Port1.edge(3 of 4) -> middle of Port1.edge(1 of 4)} CharImp=Zpi RenormImp=50ohm}} Impedance=50ohm
mesh:
  initial mesh: GlobalSurfApproximation{CurvedSurfaceApproxChoice=UseSlider SliderMeshSettings=7} DynamicSurfaceResolution
setups:
  Setup1: HfssDriven Frequency=3.6GHz MaxDeltaS=0.02 MaximumPasses=6 MinimumPasses=1 MinimumConvergedPasses=1 PercentRefinement=30 BasisOrder=1 PortAccuracy=2
    sweep Sweep: 3.2GHz to 4GHz, 401 points; Type=Interpolating SaveFields InterpTolerance=0.5 InterpMaxSolns=250 InterpUsePortImped=false PassivityErrorTolerance=0.0001
source amplitudes:
  1:1: 1W 0deg
radiation setups:
  Infinite Sphere1: Infinite Sphere Theta=-180deg..180deg step 2deg Phi=-180deg..180deg step 2deg
field plots:
  Mag_E 0deg: E Field over AntennaPlane.face(all 4) on Setup1 : LastAdaptive at Freq=3.6GHz Phase=0deg
  Mag_E 90deg: E Field over AntennaPlane.face(all 4) on Setup1 : LastAdaptive at Freq=3.6GHz Phase=90deg
  Mag_Jsurf1: Jsurf over AntennaPlane.face(all 4) MetallicSheet.face(all 32) on Setup1 : LastAdaptive at Freq=3.6GHz Phase=0deg
reports:
  S11: dB(S(1,1)) vs Freq on Setup1 : Sweep
  Axial Ratio - WIP: dB(AxialRatioValue) vs Freq on Setup1 : Sweep, Infinite Sphere1 [Phi=0deg Theta=0deg]
  Gain Plot 3D: dB(GainTotal) vs Phi, Theta on Setup1 : LastAdaptive, Infinite Sphere1 [Freq=3.4GHz]
  Gain Plot XZ: dB(GainLHCP), dB(GainRHCP) vs Theta on Setup1 : LastAdaptive, Infinite Sphere1 [Phi=0deg Freq=3.4GHz]
  Gain Plot YZ: dB(GainLHCP) vs Theta on Setup1 : LastAdaptive, Infinite Sphere1 [Phi=90deg Freq=3.4GHz]; dB(GainRHCP) vs Theta on Setup1 : LastAdaptive, Infinite Sphere1 [Phi=0deg Freq=3.4GHz]
